# Ansys Electronics Desktop project, version 2024.1
materials:
  copper: permeability=0.999991 conductivity=58000000
  FR4_epoxy: permittivity=4.4 dielectric_loss_tangent=0.02
  vacuum: permittivity=1

design HFSSDesign1 (HFSS, HFSS Modal Network, model units mm)
variables:
  H = 0.508mm
  subX = 10.5mm
  subY = 10.5mm
  Hcond = 0.035mm
  Rfora = Rdentro+Wqw
  Rdentro = Lqw/(2*pi)
  W0 = 1.2mm
  L0 = 1.28mm
  Wqw = 1.8333mm
  Lqw = 71.11967mm
  Rmin = Rdentro+W0
geometry:
  coordinate_system RelativeCS1 = origin=(subX/2, subY/2, H) x=(1mm, 0mm, 0mm) y=(0mm, 1mm, 0mm)
  Substrato [vacuum] = box(corner=(-subX/2, -subY/2, 0mm), size=(subX/2, subY/2, H)) in RelativeCS1
  Condutor [vacuum] = cylinder(axis=Z, base_centre=(0mm, 0mm, 0mm), radius=Rfora, height=Hcond) in RelativeCS1
  Centro = cylinder(axis=Z, base_centre=(0mm, 0mm, 0mm), radius=Rdentro, height=Hcond) in RelativeCS1
  Condutor.subtract(Centro)
  Box1 = box(corner=(Rfora*0.98, -W0/2, 0mm), size=(L0, W0, Hcond)) in RelativeCS1
  Box1_1, Box1_2, Box1_3 = Box1.duplicate_around_axis(axis=Z, angle=90deg, total=4) in RelativeCS1
  Condutor.unite(Box1_3, Box1_2, Box1_1, Box1)
  Rectangle1 = rectangle(corner=(2.8mm, 0.6mm, 0.035mm), z_size=-0.035mm, x_size=1.2mm) in RelativeCS1
  Condutor_Split1 = Condutor.split(plane=Rectangle1_1.face, keep=Both) in RelativeCS1
  Rectangle1_1 = Rectangle1.copy()
  Rectangle1_1.delete()
  Rectangle1_2 = Rectangle1.duplicate_mirror(point=(0.5mm, 0mm, 0mm), normal=(0mm, -1mm, 0mm)) in RelativeCS1
  Condutor_Split2 = Condutor.split(plane=Rectangle1_2_1.face, keep=Both) in RelativeCS1
  Rectangle1_2_1 = Rectangle1_2.copy()
  Rectangle1_2_1.delete()
  Rectangle1_2_2 = Rectangle1_2.duplicate_around_axis(axis=Z, angle=90deg, total=2) in RelativeCS1
  Rectangle1_2.delete()
  Rectangle1_3 = Rectangle1.duplicate_around_axis(axis=Z, angle=90deg, total=2) in RelativeCS1
  Rectangle1.delete()
  Condutor_Split1_Split1 = Condutor_Split1.split(plane=Rectangle1_2_2_1.face, keep=Both) in RelativeCS1
  Rectangle1_2_2_1 = Rectangle1_2_2.copy()
  Rectangle1_2_2_1.delete()
  Condutor_Split1_Split2 = Condutor_Split1.split(plane=Rectangle1_3_1.face, keep=Both) in RelativeCS1
  Rectangle1_3_1 = Rectangle1_3.copy()
  Rectangle1_3_1.delete()
  Condutor_Split2_Split1 = Condutor_Split2.split(plane=Rectangle1_2_2_2.face, keep=Both) in RelativeCS1
  Rectangle1_2_2_2 = Rectangle1_2_2.copy()
  [Rectangle1_2_2, Rectangle1_2_2_2].delete()
  Condutor_Split2_Split2 = Condutor_Split2.split(plane=Rectangle1_3_2.face, keep=Both) in RelativeCS1
  Rectangle1_3_2 = Rectangle1_3.copy()
  [Rectangle1_3, Rectangle1_3_2].delete()
  Cylinder1 = cylinder(axis=Z, base_centre=(0mm, 0mm, 0mm), radius=Rmin, height=0.06mm) in RelativeCS1
  Cylinder2 = cylinder(axis=Z, base_centre=(0mm, 0mm, 0mm), radius=Rfora, height=0.06mm) in RelativeCS1
  Cylinder2.subtract(Cylinder1)
  Cylinder2_1 = Cylinder2.copy()
  Condutor_Split1_Split1.subtract(Cylinder2_1)
  Condutor_Split2_Split2.subtract(Cylinder2)
  Condutor.unite(Condutor_Split2_Split2, Condutor_Split1_Split2, Condutor_Split1, Condutor_Split1_Split1, Condutor_Split2, Condutor_Split2_Split1)
