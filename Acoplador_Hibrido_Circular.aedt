# Ansys Electronics Desktop project, version 2024.1
materials:
  copper: permeability=0.999991 conductivity=58000000
  FR4_epoxy: permittivity=4.4 dielectric_loss_tangent=0.02
  vacuum: permittivity=1
  pec: conductivity=1e+30
  Rogers RO4003C 2.5GHz: permittivity=3.55 dielectric_loss_tangent=0.0021

design HFSSDesign1 (HFSS, HFSS Modal Network, model units mm)
variables:
  H = 0.508mm
  subX = (Rfora + L0)*2
  subY = (Rfora + L0)*2
  Hcond = 0.035mm
  Rfora = Rdentro+Wqw
  Rdentro = Lqw/(2*pi)
  W0 = 0.9688mm
  L0 = 1.28mm
  Wqw = 1.645mm
  Lqw = 70mm
  Rmin = Rdentro+W0
geometry:
  coordinate_system RelativeCS1 = origin=(subX/2, subY/2, H) x=(1mm, 0mm, 0mm) y=(0mm, 1mm, 0mm)
  Substrato [Rogers RO4003C 2.5GHz] = box(corner=(-subX/2, -subY/2, -H), size=(subX, subY, H)) in RelativeCS1
  Condutor = cylinder(axis=Z, base_centre=(0mm, 0mm, 0mm), radius=Rfora, height=Hcond) in RelativeCS1
  Centro = cylinder(axis=Z, base_centre=(0mm, 0mm, 0mm), radius=Rdentro, height=Hcond) in RelativeCS1
  Condutor.subtract(Centro)
  coordinate_system RelativeCS2 = origin=(Rfora, 0mm, 0) x=(1mm, 0mm, 0mm) y=(0mm, 1mm, 0mm) in RelativeCS1
  Box1 = box(corner=(-(Rfora-Rdentro)/2, -W0/2, 0mm), size=(L0 + (Rfora-Rdentro)/2, W0, Hcond)) in RelativeCS2
  Rectangle1 = rectangle(corner=(2.8mm, W0/2, Hcond), z_size=-0.035mm, x_size=1.2mm) in RelativeCS1
  Condutor_Split1 = Condutor.split(plane=Rectangle1_1.face, keep=Both) in RelativeCS1
  Rectangle1_1 = Rectangle1.copy()
  Rectangle1_1.delete()
  Rectangle1_2 = Rectangle1.duplicate_mirror(point=(0.5mm, 0mm, 0mm), normal=(0mm, -1mm, 0mm)) in RelativeCS1
  Condutor_Split2 = Condutor.split(plane=Rectangle1_2_1.face, keep=Both) in RelativeCS1
  Rectangle1_2_1 = Rectangle1_2.copy()
  Rectangle1_2_1.delete()
  Rectangle1_2_2 = Rectangle1_2.duplicate_around_axis(axis=Z, angle=90deg, total=2) in RelativeCS1
  Rectangle1_2.delete()
  Rectangle1_3 = Rectangle1.duplicate_around_axis(axis=Z, angle=90deg, total=2) in RelativeCS1
  Rectangle1.delete()
  Condutor_Split1_Split1 = Condutor_Split1.split(plane=Rectangle1_2_2_1.face, keep=Both) in RelativeCS1
  Rectangle1_2_2_1 = Rectangle1_2_2.copy()
  Rectangle1_2_2_1.delete()
  Condutor_Split1_Split2 = Condutor_Split1.split(plane=Rectangle1_3_1.face, keep=Both) in RelativeCS1
  Rectangle1_3_1 = Rectangle1_3.copy()
  Rectangle1_3_1.delete()
  Condutor_Split2_Split1 = Condutor_Split2.split(plane=Rectangle1_2_2_2.face, keep=Both) in RelativeCS1
  Rectangle1_2_2_2 = Rectangle1_2_2.copy()
  [Rectangle1_2_2, Rectangle1_2_2_2].delete()
  Condutor_Split2_Split2 = Condutor_Split2.split(plane=Rectangle1_3_2.face, keep=Both) in RelativeCS1
  Rectangle1_3_2 = Rectangle1_3.copy()
  [Rectangle1_3, Rectangle1_3_2].delete()
  Cylinder1 = cylinder(axis=Z, base_centre=(0mm, 0mm, 0mm), radius=Rmin, height=0.06mm) in RelativeCS1
  Cylinder2 = cylinder(axis=Z, base_centre=(0mm, 0mm, 0mm), radius=Rfora, height=0.06mm) in RelativeCS1
  Cylinder2.subtract(Cylinder1)
  Cylinder2_1 = Cylinder2.copy()
  Condutor_Split1_Split1.subtract(Cylinder2_1)
  Condutor_Split2_Split2.subtract(Cylinder2)
  Condutor.unite(Condutor_Split2_Split2, Condutor_Split1_Split2, Condutor_Split1, Condutor_Split1_Split1, Condutor_Split2, Condutor_Split2_Split1)
  condutor_1 [pec], Box1_1, Box1_2 = Box1.duplicate_around_axis(axis=Z, angle=90deg, total=4) in RelativeCS1
  condutor_1.unite(Condutor, Box1, Box1_1, Box1_2)
  Region [vacuum] = region(percentage_offset: +X=10, -X=10, +Y=10, -Y=10, +Z=100, -Z=100) in RelativeCS1
  Rectangle2 = rectangle(corner=(L0, -W0/2, Hcond), y_size=W0, z_size=-Hcond-H) in RelativeCS2
  Rectangle2_1, Rectangle2_2, Rectangle2_3 = Rectangle2.duplicate_around_axis(axis=Z, angle=90deg, total=4) in RelativeCS1
boundaries and excitations:
  PerfE1: Perfect E Faces=Substrato.face(at (14.0658, 14.0658, 0))
  1: Lumped Port Faces=Rectangle2.face(at (28.1317, 14.0658, 0.2715)) LumpedPortType=Default Modes{Mode1{IntLine{(28.131692, 14.065846, 0) -> (28.131692, 14.065846, 0.543)} CharImp=Zpi RenormImp=50ohm}} Impedance=50ohm
  2: Lumped Port Objects=Rectangle2_3 LumpedPortType=Default Modes{Mode1{IntLine{(14.065846, 0, 0) -> (14.065846, 0, 0.543)} CharImp=Zpi RenormImp=50ohm}} Impedance=50ohm
  3: Lumped Port Objects=Rectangle2_2 LumpedPortType=Default Modes{Mode1{IntLine{(0, 14.065846, 0) -> (0, 14.065846, 0.543)} CharImp=Zpi RenormImp=50ohm}} Impedance=50ohm
  4: Lumped Port Objects=Rectangle2_1 LumpedPortType=Default Modes{Mode1{IntLine{(14.065846, 28.131692, 0) -> (14.065846, 28.131692, 0.543)} CharImp=Zpi RenormImp=50ohm}} Impedance=50ohm
setups:
  FC: HfssDriven MultipleAdaptiveFreqsSetup{Low=1GHz High=3.8GHz} MaxDeltaS=0.02 MaximumPasses=30 MinimumPasses=1 MinimumConvergedPasses=1 PercentRefinement=30 BasisOrder=-1 PortAccuracy=2 DrivenSolverType="Direct Solver" ConstantDelta=0s
source amplitudes:
  1:1: 1W 0deg
  2:1, 3:1, 4:1: 0W 0deg
reports:
  S Parameter Plot 1: dB(S(1,1)), dB(S(2,1)), dB(S(3,1)), dB(S(4,1)) vs Freq on FC : LastAdaptive
